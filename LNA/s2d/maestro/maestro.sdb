ADE simulation setup
Run mode: Single Run, Sweeps and Corners
Tests:
  LNA_s2d_1: LNA/s2d/schematic, simulator spectre
