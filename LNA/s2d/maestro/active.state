ADE simulation setup
Test LNA_s2d_1: LNA/s2d/schematic, simulator spectre
  Models: /home/install/FOUNDRY/analog/180nm/models/spectre/gpdk.scs[NN]
  Temperature: 27
Run mode: Single Run, Sweeps and Corners
