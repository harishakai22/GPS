ADE simulation setup
Test ADC_TnH_tb_1: ADC/TnH_tb/schematic, simulator spectre
  Models: /home/install/FOUNDRY/analog/180nm/models/spectre/gpdk.scs[stat], /home/install/FOUNDRY/analog/45nm/gpdk045/../models/spectre/gpdk045.scs[mc]
  Temperature: 27
  Analysis tran: stop=375n
  Signals: /vin, /clk, /vout
Run mode: Single Run, Sweeps and Corners
