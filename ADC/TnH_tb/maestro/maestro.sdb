ADE simulation setup
Run mode: Single Run, Sweeps and Corners
Tests:
  ADC_TnH_tb_1: ADC/TnH_tb/schematic, simulator spectre
    Outputs: /vin; /clk; /vout
