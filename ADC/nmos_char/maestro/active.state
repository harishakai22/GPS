ADE simulation setup
Test adc_nmos_char_1: adc/nmos_char/schematic, simulator spectre
  Models: /home/install/FOUNDRY/analog/180nm/models/spectre/gpdk.scs[stat]
  Temperature: 27
  Analysis dc: (saves the operating point)
  Output Ron = (1.8 / IDC("/NM0/D"))
  Signals: /NM0/D (terminal)
Run mode: Single Run, Sweeps and Corners
