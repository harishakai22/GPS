ADE simulation setup
Run mode: Single Run, Sweeps and Corners
Tests:
  adc_nmos_char_1: adc/nmos_char/schematic, simulator spectre
