ADE simulation setup
Run mode: Single Run, Sweeps and Corners
Tests:
  ADC_nmos_1: ADC/nmos/schematic, simulator spectre
    Variables: width = 1u:1u:20u
    Outputs: (0.7 / IDC("/NM0/D"))
