ADE simulation setup
Test ADC_nmos_1: ADC/nmos/schematic, simulator spectre
  Models: /home/install/FOUNDRY/analog/180nm/models/spectre/gpdk.scs[stat]
  Variables: width = 1u
  Temperature: 27
  Analysis dc: (saves the operating point)
  Output ((VDC("/net2") - VDC("/net1")) / IDC("/NM0/D"))
  Signals: /NM0/D (terminal)
Run mode: Single Run, Sweeps and Corners
Setup values for test ADC_nmos_1: width = 1u:1u:20u
