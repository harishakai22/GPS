ADE simulation setup
Run mode: Single Run, Sweeps and Corners
Tests:
  ADC_15comp_1: ADC/15comp/schematic, simulator spectre
    Outputs: (VDC("/o1") + VDC("/o2") + VDC("/o3") + VDC("/o4") + VDC("/o5") + VDC("/o6") + VDC("/o7") + VDC("/o8") + VDC("/o9") + VDC("/o10") + VDC("/o11") + VDC("/o12") + VDC("/o13") + VDC("/o14") + VDC("/o15")); (VDC("/o1")); /vin; ((((VT("/o1") + VT("/o2") + VT("/o3") + VT("/o4") + VT("/o5") + VT("/o6") + VT("/o7") + VT("/o8") + VT("/o9") + VT("/o10") + VT("/o11") + VT("/o12") + VT("/o13") + VT("/o14") + VT("/o15")) / 1.8) * 1.2) / 15); (((VT("/o1") + VT("/o2") + VT("/o3") + VT("/o4") + VT("/o5") + VT("/o6") + VT("/o7") + VT("/o8") + VT("/o9") + VT("/o10") + VT("/o11") + VT("/o12") + VT("/o13") + VT("/o14") + VT("/o15")) / 1.8 / 12.5)); ((VT("/o1") + VT("/o2") + VT("/o3") + VT("/o4") + VT("/o5") + VT("/o6") + VT("/o7") + VT("/o8") + VT("/o9") + VT("/o10") + VT("/o11") + VT("/o12") + VT("/o13") + VT("/o14") + VT("/o15"))); (((VT("/o1") + VT("/o2") + VT("/o3") + VT("/o4") + VT("/o5") + VT("/o6") + VT("/o7") + VT("/o8") + VT("/o9") + VT("/o10") + VT("/o11") + VT("/o12") + VT("/o13") + VT("/o14") + VT("/o15"))) / 22.5); ((VT("/o1") + VT("/o2") + VT("/o3") + VT("/o4") + VT("/o5") + VT("/o6") + VT("/o7") + VT("/o8") + VT("/o9") + VT("/o10") + VT("/o11") + VT("/o12") + VT("/o13") + VT("/o14") + VT("/o15")) / 22.5); /I42/P; /I42/Q; /I42/X; /I42/Y; (VT("/vin") - 0.6); ((VT("/o1") + VT("/o2") + VT("/o3") + VT("/o4") + VT("/o5") + VT("/o6") + VT("/o7") + VT("/o8") + VT("/o9") + VT("/o10") + VT("/o11") + VT("/o12") + VT("/o13") + VT("/o14") + VT("/o15")) / (1.8 * 15)); ((VT("/o1") + VT("/o2") + VT("/o3") + VT("/o4") + VT("/o5") + VT("/o6") + VT("/o7") + VT("/o8") + VT("/o9") + VT("/o10") + VT("/o11") + VT("/o12") + VT("/o13") + VT("/o14") + VT("/o15")) / (1.8 * 16)); (-1 * average((IT("/V0/PLUS") * VT("/vsupply")))); (- (VT("/vsupply") * IT("/V0/PLUS")))
