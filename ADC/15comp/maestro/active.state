ADE simulation setup
Test ADC_Comparatorblock_1: ADC/Comparatorblock/schematic, simulator spectre
  Models: /home/install/FOUNDRY/analog/180nm/models/spectre/gpdk.scs[stat]
  Temperature: 27
  Analysis tran: stop=1u
  Signals: /out, /vin, /clk, /vref
