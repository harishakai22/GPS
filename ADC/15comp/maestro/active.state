ADE simulation setup
Test ADC_15comp_1: ADC/15comp/schematic, simulator spectre
  Models: /home/install/FOUNDRY/analog/180nm/models/spectre/gpdk.scs[stat]
  Temperature: 27
  Analysis tran: stop=500n
  Output output of thermometer sum = ((VT("/o1") + VT("/o2") + VT("/o3") + VT("/o4") + VT("/o5") + VT("/o6") + VT("/o7") + VT("/o8") + VT("/o9") + VT("/o10") + VT("/o11") + VT("/o12") + VT("/o13") + VT("/o14") + VT("/o15")) / (1.8 * 15))
  Output v /o1; tran (V) = vtime('tran "/o1")
  Output v /o2; tran (V) = vtime('tran "/o2")
  Output v /o3; tran (V) = vtime('tran "/o3")
  Output v /o4; tran (V) = vtime('tran "/o4")
  Output v /o5; tran (V) = vtime('tran "/o5")
  Output v /o6; tran (V) = vtime('tran "/o6")
  Output v /o7; tran (V) = vtime('tran "/o7")
  Output v /o8; tran (V) = vtime('tran "/o8")
  Output v /o9; tran (V) = vtime('tran "/o9")
  Output v /o10; tran (V) = vtime('tran "/o10")
  Output v /o11; tran (V) = vtime('tran "/o11")
  Output v /o12; tran (V) = vtime('tran "/o12")
  Output v /o13; tran (V) = vtime('tran "/o13")
  Output v /o14; tran (V) = vtime('tran "/o14")
  Output v /o15; tran (V) = vtime('tran "/o15")
  Output (VT("/vin") - 0.6)
  Output VT("/clk")
  Output IT("/V0/PLUS")
  Output (-1 * average((IT("/V0/PLUS") * VT("/vsupply"))))
  Output (- (VT("/vsupply") * IT("/V0/PLUS")))
  Output v /vinput; tran (V) = vtime('tran "/vinput")
  Output spectrum_v /vinput; tran (V) = db20(dft(vtime('tran "/vinput") 0.0 2.56e-05 1024 "Rectangular" 0 0 1))
  Output (VT("/vinput") - 0.6)
  Output spectrum_enob = spectrumMeasurement((VT("/vinput") - 0.6) t 0.0 2.56e-05 1024 39060.0 2e+07 0 "Rectangular" 0.0 0 1 "enob")
  Signals: /vin, /V0/PLUS (terminal), /I0/NM2/D (terminal)
Run mode: Single Run, Sweeps and Corners
