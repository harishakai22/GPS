ADE simulation setup
Test ADC_15comp_1: ADC/15comp/schematic, simulator spectre
  Models: /home/install/FOUNDRY/analog/180nm/models/spectre/gpdk.scs[NN]
  Temperature: 27
  Analysis tran: stop=5u strobeperiod=25n
  Output output of thermometer sum = ((VT("/o1") + VT("/o2") + VT("/o3") + VT("/o4") + VT("/o5") + VT("/o6") + VT("/o7") + VT("/o8") + VT("/o9") + VT("/o10") + VT("/o11") + VT("/o12") + VT("/o13") + VT("/o14") + VT("/o15")) / (1.8 * 15))
  Output (VT("/vin") - 0.6)
  Output VT("/clk")
  Output IT("/V0/PLUS")
  Output (-1 * average((IT("/V0/PLUS") * VT("/vsupply"))))
  Output (- (VT("/vsupply") * IT("/V0/PLUS")))
  Output v /vinput; tran (V) = vtime('tran "/vinput")
  Output spectrum_v /vinput; tran (V) = db20(dft(vtime('tran "/vinput") 0.0 2.56e-05 1024 "Rectangular" 0 0 1))
  Output (VT("/vinput") - 0.6)
  Output spectrum_enob = spectrumMeasurement((VT("/vinput") - 0.6) t 0.0 2.56e-05 1024 39060.0 2e+07 0 "Rectangular" 0.0 0 1 "enob")
  Output v /d3; tran (V) = vtime('tran "/d3")
  Output v /d2; tran (V) = vtime('tran "/d2")
  Output v /d1; tran (V) = vtime('tran "/d1")
  Output v /d0; tran (V) = vtime('tran "/d0")
  Output ((8 * vtime('tran "/d3")) + (4 * vtime('tran "/d2")) + (2 * vtime('tran "/d1")) + vtime('tran "/d0"))
  Signals: /vin, /V0/PLUS (terminal), /I0/NM2/D (terminal)
