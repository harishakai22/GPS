ADE simulation setup
Run mode: Single Run, Sweeps and Corners
Tests:
  ADC_adc_ideal_sim_1: ADC/adc_ideal_sim/schematic, simulator spectre
    Outputs: /vo1; /vo2; /vo3; /vo4; /net2; /vout; /net1; /vclock; /vin
