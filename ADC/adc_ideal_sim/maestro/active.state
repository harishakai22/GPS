ADE simulation setup
Test ADC_adc_ideal_sim_1: ADC/adc_ideal_sim/schematic, simulator spectre
  Models: /home/install/FOUNDRY/analog/180nm/models/spectre/gpdk.scs[stat]
  Temperature: 27
  Analysis tran: stop=50u strobeperiod=25n
  Signals: /vo1, /vo2, /vo3, /vo4, /vin, /vout, /vclock
Run mode: Single Run, Sweeps and Corners
