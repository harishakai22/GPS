ADE simulation setup
Run mode: Monte Carlo Sampling
Tests:
  ADC:15comp:1: ADC/15comp/schematic, simulator spectre
Monte Carlo Sampling options: mcmethod=all, mcnumpoints=4
