ADE simulation setup
Run mode: Single Run, Sweeps and Corners
Tests:
  ADC_Comparatorblock_1: ADC/Comparatorblock/schematic, simulator spectre
    Outputs: /out; /vin; /clk; /vref
