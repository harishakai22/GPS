// VerilogA for ADC, dac_4bit, veriloga

`include "constants.vams"
`include "disciplines.vams"

// $Date: 1997/08/28 05:54:36 $
// $Revision: 1.1 $
//
//

//--------------------
// dac_8bit_ideal
//
// -  8 bit digital analog converter
//
// vd0..vd7:	data inputs [V,A]
// vout:	[V,A]
//
// INSTANCE parameters
//    vref   = reference voltage that conversion is with respect to [V]
//    vtrans = transition voltage between logic high and low [V]
//    tdel,trise,tfall = {usual} [s]
//
// MODEL parameters
//    {none}

/*module dac_8bit_ideal (vd3, vd2, vd1, vd0, vout);
electrical vd3, vd2, vd1, vd0, vout;
parameter real vref  = 1.0 from [0:inf);
parameter real trise = 0 from [0:inf);
parameter real tfall = 0 from [0:inf);
parameter real tdel  = 0 from [0:inf);
parameter real vtrans  = 0.9;

    real out_scaled; // output scaled as fraction of 256

    analog begin
		out_scaled = 0;
		//out_scaled = out_scaled + ((V(vd7) > vtrans) ? 128 : 0);
		//out_scaled = out_scaled + ((V(vd6) > vtrans) ? 64 : 0);
		//out_scaled = out_scaled + ((V(vd5) > vtrans) ? 32 : 0);
		//out_scaled = out_scaled + ((V(vd4) > vtrans) ? 16 : 0);
		out_scaled = out_scaled + ((V(vd3) > vtrans) ? 8 : 0);
		out_scaled = out_scaled + ((V(vd2) > vtrans) ? 4 : 0);
		out_scaled = out_scaled + ((V(vd1) > vtrans) ? 2 : 0);
		out_scaled = out_scaled + ((V(vd0) > vtrans) ? 1 : 0);
		V(vout) <+ transition( vref*out_scaled/16, tdel, trise, tfall );
    end
endmodule
*/

`include "constants.vams"
`include "disciplines.vams"

module dac_4bit_ideal_dac_4bit(d0,d1,d2,d3,vout,vdd,vss,vmin,vmax);

parameter real vtrans=0.5;
parameter real delay = 0;
parameter real ttime = 1p;

inout vdd,vss;
input d0,d1,d2,d3;
input vmin, vmax;
output vout;

electrical vout,vdd,vss,d0,d1,d2,d3,vmin,vmax;

real result,d_0,d_1,d_2,d_3;

analog begin
	d_3 = V(d3)*8;
	d_2 = V(d2)*4;
	d_1 = V(d1)*2;
	d_0 = V(d0)*1;

	result = ((d_3+d_2+d_1+d_0) * ((V(vmax)-V(vmin))/(16))) + V(vmin) ;

	V(vout) <+ transition(result,delay,ttime);
end

endmodule
