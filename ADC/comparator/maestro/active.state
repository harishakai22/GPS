ADE simulation setup
Test ADC:comparator:1: ADC/comparator/schematic, simulator spectre
  Models: /home/install/FOUNDRY/analog/180nm/models/spectre/gpdk.scs[stat]
  Temperature: 27
  Analysis tran: stop=10n
  Signals: /net06
Run mode: Single Run, Sweeps and Corners
