ADE simulation setup
Test ADC:comparator:1: ADC/comparator/schematic, simulator spectre
  Models: /home/install/FOUNDRY/analog/180nm/models/spectre/gpdk.scs[stat]
  Temperature: 27
  Analysis tran: stop=100n
  Output riseTime(VT("/vout") 0 nil 1.8 nil 10 90 t "time")
  Output fallTime(VT("/vout") 1.8 nil 0 nil 10 90 t "cycle")
  Signals: /vout, /vin
Run mode: Single Run, Sweeps and Corners
