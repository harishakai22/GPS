ADE simulation setup
Run mode: Single Run, Sweeps and Corners
Tests:
  ADC:comparator:1: ADC/comparator/schematic, simulator spectre
    Outputs: /net06; /vout; /vin
