ADE simulation setup
Run mode: Single Run, Sweeps and Corners
Tests:
  ADC:compfirstpass:1: ADC/compfirstpass/schematic, simulator spectre
    Outputs: /clk; /net6; /net24; /X; /Y
