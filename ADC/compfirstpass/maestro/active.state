ADE simulation setup
Test ADC:compfirstpass:1: ADC/compfirstpass/schematic, simulator spectre
  Models: /home/install/FOUNDRY/analog/180nm/models/spectre/gpdk.scs[NN]
  Temperature: 27
  Analysis dc: (saves the operating point)
Run mode: Single Run, Sweeps and Corners
