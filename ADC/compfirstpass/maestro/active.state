ADE simulation setup
Test ADC:compfirstpass:1: ADC/compfirstpass/schematic, simulator spectre
  Models: /home/install/FOUNDRY/analog/180nm/models/spectre/gpdk.scs[NN]
  Temperature: 27
  Operating points saved: /NM4 (css cdd)
  Analysis tran: stop=100n
  Analysis dc: (saves the operating point)
  Output (VT("/net34") - VT("/net35"))
  Signals: /clk, /X, /Y
Run mode: Single Run, Sweeps and Corners
